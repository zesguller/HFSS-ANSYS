# Ansys Electronics Desktop project, version 2022.1
materials:
  vacuum: permittivity=1
  Teflon (tm): permittivity=2.1 dielectric_loss_tangent=0.001
  pec: conductivity=1e+30
  FR4_epoxy: permittivity=4.4 dielectric_loss_tangent=0.02

design HFSSDesign1 (HFSS, DrivenModal, model units mm)
variables:
  taban_boy = 30mm
  taban_en = 30mm
  yükseklik = 6mm
  patch_boy = 17mm
  patch_en = 22mm
  x_kayma = 0mm
  y_kayma = 0mm
  inner_radius = 0.1mm
  outer_rad = 1.1mm
  orta_rad = 0.8mm
  outer_h = -7mm
  ic_en = 8.9mm
  dys_en = 10.5mm
  dıs_en = 10.5mm
  fark = 1.7mm
  ic_boy = 10mm
  out_en = 10.5mm
  out_boy = 11.5mm
geometry:
  taban = rectangle(corner=(-taban_boy/2, -taban_en/2, 0mm), x_size=taban_boy, y_size=taban_en)
  substrate [FR4_epoxy] = box(corner=(-taban_boy/2, -taban_en/2, 0mm), size=(taban_boy, taban_en, yükseklik))
  patch = rectangle(corner=(-patch_boy/2, -patch_en/2, yükseklik), x_size=patch_boy, y_size=patch_en)
  outer_conductor [pec] = cylinder(axis=Z, base_centre=(0mm, y_kayma, 0mm), radius=outer_rad, height=outer_h)
  dielectric [Teflon (tm)] = cylinder(axis=Z, base_centre=(0mm, y_kayma, 0mm), radius=orta_rad, height=outer_h)
  probe_pin [pec] = cylinder(axis=Z, base_centre=(0mm, y_kayma, yükseklik), radius=inner_radius, height=outer_h-yükseklik)
  port = circle(normal=Z, centre=(0mm, y_kayma, outer_h), radius=outer_rad)
  probe_pin_1 = probe_pin.copy()
  substrate.subtract(probe_pin_1)
  dielectric_1 = dielectric.copy()
  outer_conductor.subtract(dielectric_1)
  probe_pin_2 = probe_pin.copy()
  dielectric.subtract(probe_pin_2)
  probe_pin_3 = probe_pin.copy()
  substrate.subtract(probe_pin_3)
  pecCap1 [pec] = sweep_along_normal(port.face(at (0, 0, -7)), length=-0.21mm)
  Region [vacuum] = region(percentage_offset=30 on all sides)
  Circle1 = circle(normal=Z, centre=(0mm, y_kayma, 0mm), radius=outer_rad)
  taban.subtract(Circle1)
  patch.rotate(axis=Z, angle=270deg)
  Rectangle1 = rectangle(corner=(-out_en/2, -out_boy/2, 6mm), x_size=out_en, y_size=out_boy)
  Rectangle2 = rectangle(corner=(-(out_en-2*fark)/2, -(out_boy-2*fark)/2, 6mm), x_size=out_en-2*fark, y_size=out_boy-fark)
  patch.subtract(Rectangle1)
  patch.unite(Rectangle2)
  patch.rotate(axis=Z, angle=270deg)
  patch.rotate(axis=Z, angle=180deg)
  Cylinder1 = cylinder(axis=Z, base_centre=(-13mm, -11.5mm, 6mm), radius=0.5mm, height=-6mm)
  Cylinder1_1 = Cylinder1.duplicate_mirror(point=(-10mm, 0mm, 0mm), normal=(0mm, 1mm, 0mm))
  Cylinder1_2 = Cylinder1.duplicate_mirror(point=(0mm, -12mm, 0mm), normal=(1mm, 0mm, 0mm))
  Cylinder1_1_1 = Cylinder1_1.duplicate_mirror(point=(0mm, 12mm, 0mm), normal=(1mm, 0mm, 0mm))
  substrate.subtract(Cylinder1, Cylinder1_1, Cylinder1_1_1, Cylinder1_2)
  ust_duvar [pec] = box(corner=(-(taban_boy/2+0.5mm), 15mm, 0mm), size=(0.5mm, -30mm, 18mm))
  alt_duvar [pec] = box(corner=(taban_en/2, 15mm, 0mm), size=(0.5mm, -30mm, 18mm))
  alt_duvar_1 = alt_duvar.copy()
  ust_duvar_1 = ust_duvar.copy()
  substrate.subtract(alt_duvar_1, ust_duvar_1)
  alt_duvar_2 = alt_duvar.copy()
  ust_duvar_2 = ust_duvar.copy()
  taban.subtract(alt_duvar_2, ust_duvar_2)
boundaries and excitations:
  PerfE2: Perfect E Objects=patch
  PerfE3: Perfect E Objects=taban
  PerfE4: Perfect E Objects=port
  Rad1: Radiation Objects=Region
  PerfE6: Perfect E Objects=[alt_duvar, ust_duvar]
  1: Wave Port Objects=port NumModes=1 Modes{Mode1{IntLine{(0, 0, -7) -> (0, 1.1, -7)} CharImp=Zpi}}
setups:
  Setup1: HfssDriven Frequency=3.6GHz MaxDeltaS=0.02 MaximumPasses=6 MinimumPasses=1 MinimumConvergedPasses=1 PercentRefinement=30 BasisOrder=1 PortAccuracy=2 DrivenSolverType="Direct Solver"
    sweep Sweep: point 3.22GHz; SaveSingleField Type=Discrete
    sweep Sweep1: point 3.22GHz; SaveSingleField Type=Discrete
source amplitudes:
  1:1: 1W 0deg
radiation setups:
  ff_2d: Infinite Sphere Theta=-180deg..180deg step 2deg Phi=0deg..90deg step 90deg
  Infinite Sphere1: Infinite Sphere Theta=-180deg..180deg step 2deg Phi=0deg..90deg step 90deg
reports:
  Gain Plot 1: dB(GainTotal) vs Theta on Setup1 : Sweep, Infinite Sphere1 [Phi=all Freq=3.22GHz]
  Gain Plot 2: dB(GainTotal) vs Theta on Setup1 : Sweep1, Infinite Sphere1 [Phi=all Freq=3.22GHz]
