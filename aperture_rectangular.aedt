# Ansys Electronics Desktop project, version 2022.1
materials:
  vacuum: permittivity=1
  FR4_epoxy: permittivity=4.4 dielectric_loss_tangent=0.02

design HFSSDesign1 (HFSS, DrivenModal, model units mm)
variables:
  taban_boy = 50mm
  taban_en = 45mm
  alt_yükseklik = 1.8mm
  transmission_boy = -30mm
  transmission_en = 3mm
  aperture_en = 8mm
  aperture_boy = -2mm
  patch_boy = 25mm
  patch_en = 20mm
  x_shift = 0mm
geometry:
  plate = rectangle(corner=(-taban_boy/2, -taban_en/2, alt_yükseklik), x_size=taban_boy, y_size=taban_en)
  lower_substrate [FR4_epoxy] = box(corner=(-taban_boy/2, -taban_en/2, 0mm), size=(taban_boy, taban_en, alt_yükseklik))
  transmission_line = rectangle(corner=(-transmission_boy -(taban_boy/2), -transmission_en/2, 0mm), x_size=transmission_boy, y_size=transmission_en)
  aperture_cut = rectangle(corner=(-aperture_boy/2+x_shift, -aperture_en/2, alt_yükseklik), x_size=aperture_boy, y_size=aperture_en)
  plate.subtract(aperture_cut)
  upper_substrate [FR4_epoxy] = box(corner=(-taban_boy/2, -taban_en/2, alt_yükseklik), size=(taban_boy, taban_en, alt_yükseklik))
  patch = rectangle(corner=(-patch_boy/2, -patch_en/2, 2*alt_yükseklik), x_size=patch_boy, y_size=patch_en)
  port = rectangle(corner=(-taban_boy/2, -transmission_en/2, alt_yükseklik), y_size=transmission_en, z_size=-alt_yükseklik)
  RadiatingSurface [vacuum] = region(absolute_offset=27.777778mm on all sides)
boundaries and excitations:
  PerfE1: Perfect E Objects=transmission_line
  PerfE2: Perfect E Objects=patch
  PerfE3: Perfect E Objects=plate
  Open1: Radiation Objects=RadiatingSurface
  1: Lumped Port Objects=port Modes{Mode1{IntLine{(-25, 0, 0) -> (-25, 0, 1.8)} CharImp=Zpi RenormImp=50ohm}} Impedance=50ohm
setups:
  Setup1: HfssDriven Frequency=3.6GHz MaxDeltaS=0.02 MaximumPasses=6 MinimumPasses=1 MinimumConvergedPasses=1 PercentRefinement=30 BasisOrder=1 PortAccuracy=2 DrivenSolverType="Direct Solver"
    sweep Sweep: 2GHz to 5.5GHz step 0.01GHz; Type=Interpolating InterpTolerance=0.5 InterpMaxSolns=250 InterpUsePortImped=false PassivityErrorTolerance=0.0001
    sweep Sweep1: point 2.9GHz; SaveSingleField Type=Discrete
source amplitudes:
  1:1: 1W 0deg
radiation setups:
  3D: Infinite Sphere Theta=0deg..180deg step 2deg Phi=-180deg..180deg step 2deg
  Elevation: Infinite Sphere Theta=-180deg..180deg step 1deg Phi=0deg..90deg step 90deg
  Azimuth: Infinite Sphere Theta=90deg..90deg step 0deg Phi=-180deg..180deg step 1deg
  Infinite Sphere1: Infinite Sphere Theta=-180deg..180deg step 2deg Phi=0deg..90deg step 90deg
reports:
  S Parameter Plot 1: dB(S(1,1)) vs Freq on Setup1 : Sweep [taban_boy=all taban_en=all transmission_boy=all aperture_en=all patch_boy=all patch_en=all]
  Gain Plot 1: dB(GainTotal) vs Theta on Setup1 : Sweep1, Infinite Sphere1 [Phi=all Freq=2.9GHz taban_boy=all taban_en=all transmission_boy=all aperture_en=all patch_boy=all patch_en=all x_shift=all]
