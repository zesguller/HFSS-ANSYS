# Ansys Electronics Desktop project, version 2022.1
materials:
  vacuum: permittivity=1
  Teflon (tm): permittivity=2.1 dielectric_loss_tangent=0.001
  pec: conductivity=1e+30
  FR4_epoxy: permittivity=4.4 dielectric_loss_tangent=0.02

design HFSSDesign1 (HFSS, DrivenModal, model units mm)
variables:
  taban_boy = 100mm
  taban_en = 100mm
  yükseklik = 1.6mm
  patch_boy = 30mm
  patch_en = 20mm
  x_kayma = 0mm
  y_kayma = 7mm
  inner_radius = 0.51mm
  outer_rad = 2mm
  orta_rad = 1.7mm
  outer_h = -20mm
geometry:
  taban = rectangle(corner=(-taban_boy/2, -taban_en/2, 0mm), x_size=taban_boy, y_size=taban_en)
  substrate [FR4_epoxy] = box(corner=(-taban_boy/2, -taban_en/2, 0mm), size=(taban_boy, taban_en, yükseklik))
  patch = rectangle(corner=(-patch_boy/2, -patch_en/2, yükseklik), x_size=patch_boy, y_size=patch_en)
  outer_conductor [pec] = cylinder(axis=Z, base_centre=(0mm, y_kayma, 0mm), radius=outer_rad, height=outer_h)
  dielectric [Teflon (tm)] = cylinder(axis=Z, base_centre=(0mm, y_kayma, 0mm), radius=orta_rad, height=outer_h)
  probe_pin [pec] = cylinder(axis=Z, base_centre=(0mm, y_kayma, yükseklik), radius=inner_radius, height=outer_h-yükseklik)
  port = circle(normal=Z, centre=(0mm, y_kayma, outer_h), radius=outer_rad)
  probe_pin_1 = probe_pin.copy()
  substrate.subtract(probe_pin_1)
  dielectric_1 = dielectric.copy()
  outer_conductor.subtract(dielectric_1)
  probe_pin_2 = probe_pin.copy()
  dielectric.subtract(probe_pin_2)
  probe_pin_3 = probe_pin.copy()
  substrate.subtract(probe_pin_3)
  pecCap1 [pec] = sweep_along_normal(port.face(at (0, 7, -20)), length=-0.21mm)
  Region [vacuum] = region(percentage_offset=30 on all sides)
  Circle1 = circle(normal=Z, centre=(0mm, y_kayma, 0mm), radius=outer_rad)
  taban.subtract(Circle1)
boundaries and excitations:
  PerfE2: Perfect E Objects=patch
  PerfE3: Perfect E Objects=taban
  PerfE4: Perfect E Objects=port
  Rad1: Radiation Objects=Region
  1: Wave Port Objects=port NumModes=1 Modes{Mode1{IntLine{(0, 7, -20) -> (0, 9, -20)} CharImp=Zpi}}
setups:
  Setup1: HfssDriven Frequency=3.6GHz MaxDeltaS=0.02 MaximumPasses=6 MinimumPasses=1 MinimumConvergedPasses=1 PercentRefinement=30 BasisOrder=1 PortAccuracy=2 DrivenSolverType="Direct Solver"
    sweep Sweep: 1.8GHz to 5.4GHz step 0.01GHz; Type=Interpolating InterpTolerance=0.5 InterpMaxSolns=250 InterpUsePortImped=false PassivityErrorTolerance=0.0001
    sweep Sweep1: point 3.37GHz; SaveSingleField Type=Discrete
    sweep Sweep2: point 4.68GHz; SaveSingleField Type=Discrete
source amplitudes:
  1:1: 1W 0deg
radiation setups:
  Infinite Sphere1: Infinite Sphere Theta=-180deg..180deg step 2deg Phi=0deg..90deg step 90deg
field plots:
  Vector_Jsurf1: Jsurf over probe_pin.face(all 3) patch.face on Setup1 : Sweep1 at Freq=3.37GHz Phase=0deg
  Vector_Jsurf2: Jsurf over probe_pin.face(all 3) patch.face on Setup1 : Sweep2 at Freq=4.68GHz Phase=0deg
reports:
  S Parameter Plot 1: dB(S(1,1)) vs Freq on Setup1 : Sweep
  S Parameter Plot 2: dB(S(1,1)) vs Freq on Setup1 : Sweep
  S Parameter Plot 3: dB(S(1,1)) vs Freq on Setup1 : Sweep [patch_boy=all patch_en=all]
  S Parameter Plot 4: dB(S(1,1)) vs Freq on Setup1 : Sweep [patch_boy=all patch_en=all]; markers m1 at 3.37GHz, m2 at 4.68GHz
  Gain Plot 1: dB(GainTotal) vs Theta on Setup1 : Sweep1, Infinite Sphere1 [Phi=all Freq=3.37GHz patch_boy=all patch_en=all]
  Gain Plot 2: dB(GainTotal) vs Theta on Setup1 : Sweep2, Infinite Sphere1 [Phi=all Freq=4.68GHz patch_boy=all patch_en=all]
