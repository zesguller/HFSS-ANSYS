# Ansys Electronics Desktop project, version 2022.1
materials:
  vacuum: permittivity=1
  Teflon (tm): permittivity=2.1 dielectric_loss_tangent=0.001
  pec: conductivity=1e+30
  FR4_epoxy: permittivity=4.4 dielectric_loss_tangent=0.02

design HFSSDesign1 (HFSS, DrivenModal, model units mm)
variables:
  taban_boy = 50mm
  taban_en = 40mm
  yükseklik = 1.517mm
  patch_boy = 19mm
  patch_en = 19mm
  x_kayma = 0mm
  y_kayma = -3.5mm
  inner_radius = 0.7mm
  outer_rad = 3mm
  orta_rad = 2.4mm
  outer_h = -7mm
  ic_en = 8.9mm
  dys_en = 10.5mm
  dıs_en = 10.5mm
  fark = 1.7mm
  ic_boy = 10mm
  out_en = 10.5mm
  out_boy = 11.5mm
  lateral_rad1 = 5mm
  lateral_h = 7mm
  lateral_rad2 = 3mm
geometry:
  taban = rectangle(corner=(-taban_boy/2, -taban_en/2, 0mm), x_size=taban_boy, y_size=taban_en)
  substrate [FR4_epoxy] = box(corner=(-taban_boy/2, -taban_en/2, 0mm), size=(taban_boy, taban_en, yükseklik))
  patch = rectangle(corner=(-patch_boy/2, -patch_en/2, yükseklik), x_size=patch_boy, y_size=patch_en)
  outer_conductor [pec] = cylinder(axis=Z, base_centre=(0mm, y_kayma, 0mm), radius=outer_rad, height=outer_h)
  dielectric [Teflon (tm)] = cylinder(axis=Z, base_centre=(0mm, y_kayma, 0mm), radius=orta_rad, height=outer_h)
  probe_pin [pec] = cylinder(axis=Z, base_centre=(0mm, y_kayma, yükseklik), radius=inner_radius, height=outer_h-yükseklik)
  port = circle(normal=Z, centre=(0mm, y_kayma, outer_h), radius=outer_rad)
  probe_pin_1 = probe_pin.copy()
  substrate.subtract(probe_pin_1)
  dielectric_1 = dielectric.copy()
  outer_conductor.subtract(dielectric_1)
  probe_pin_2 = probe_pin.copy()
  dielectric.subtract(probe_pin_2)
  probe_pin_3 = probe_pin.copy()
  substrate.subtract(probe_pin_3)
  pecCap1 [pec] = sweep_along_normal(port.face(at (0, -3.5, -7)), length=-0.21mm)
  Circle1 = circle(normal=Z, centre=(0mm, y_kayma, 0mm), radius=outer_rad)
  taban.subtract(Circle1)
  patch.rotate(axis=Z, angle=270deg)
  patch.rotate(axis=Z, angle=270deg)
  patch.rotate(axis=Z, angle=180deg)
  ust_duvar = box(corner=(-taban_boy/2, taban_en/2, 0mm), size=(taban_boy, 0.5mm, 10mm))
  alt_duvar = box(corner=(-taban_boy/2, -taban_en/2, 0mm), size=(taban_boy, -0.5mm, 10mm))
  alt_duvar_1 = alt_duvar.copy()
  ust_duvar_1 = ust_duvar.copy()
  substrate.subtract(alt_duvar_1, ust_duvar_1)
  alt_duvar_2 = alt_duvar.copy()
  alt_duvar.delete()
  ust_duvar_2 = ust_duvar.copy()
  ust_duvar.delete()
  taban.subtract(alt_duvar_2, ust_duvar_2)
  Circle2 = circle(normal=Y, centre=(0mm, taban_en/2, lateral_h), radius=lateral_rad1)
  Circle3 = circle(normal=Y, centre=(0mm, taban_en/2, lateral_h), radius=lateral_rad2)
  Circle2.subtract(Circle3)
  Circle2_1 = Circle2.duplicate_mirror(point=(0mm, 0mm, 1.517mm), normal=(0mm, -1mm, 5.2867763e-17mm))
  Box1 [vacuum] = box(corner=(-50mm, -50mm, -50mm), size=(100mm, 100mm, 100mm))
boundaries and excitations:
  PerfE2: Perfect E Objects=patch
  PerfE3: Perfect E Objects=taban
  PerfE4: Perfect E Objects=port
  PerfE5: Perfect E Objects=Circle2
  PerfE6: Perfect E Objects=Circle2_1
  1: Wave Port Objects=port NumModes=1 Modes{Mode1{IntLine{(0, -3.5, -7) -> (0, -0.5, -7)} CharImp=Zpi}}
setups:
  Setup1: HfssDriven Frequency=3.6GHz MaxDeltaS=0.02 MaximumPasses=6 MinimumPasses=1 MinimumConvergedPasses=1 PercentRefinement=30 BasisOrder=1 PortAccuracy=2 DrivenSolverType="Direct Solver"
    sweep Sweep: 1GHz to 5GHz step 0.01GHz; Type=Interpolating InterpTolerance=0.5 InterpMaxSolns=250 InterpUsePortImped=false PassivityErrorTolerance=0.0001
source amplitudes:
  1:1: 1W 0deg
