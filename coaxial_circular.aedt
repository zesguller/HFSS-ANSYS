# Ansys Electronics Desktop project, version 2022.1
materials:
  vacuum: permittivity=1
  Teflon (tm): permittivity=2.1 dielectric_loss_tangent=0.001
  pec: conductivity=1e+30
  FR4_epoxy: permittivity=4.4 dielectric_loss_tangent=0.02

design HFSSDesign1 (HFSS, DrivenModal, model units mm)
variables:
  taban_boy = 100mm
  taban_en = 100mm
  yükseklik = 1.6mm
  x_kayma = 0mm
  y_kayma = 4.8mm
  dıs_yükseklik = 22mm
  inner_radius = 0.51mm
  outer_rad = 2mm
  orta_rad = 1.7mm
  outer_h = -15mm
  port_rad = 2mm
  patch_rad = 13mm
geometry:
  taban = rectangle(corner=(-taban_boy/2, -taban_en/2, 0mm), x_size=taban_boy, y_size=taban_en)
  substrate [FR4_epoxy] = box(corner=(-taban_boy/2, -taban_en/2, 0mm), size=(taban_boy, taban_en, yükseklik))
  outer_conductor [pec] = cylinder(axis=Z, base_centre=(0mm, y_kayma, 0mm), radius=outer_rad, height=outer_h)
  dielectric [Teflon (tm)] = cylinder(axis=Z, base_centre=(0mm, y_kayma, 0mm), radius=orta_rad, height=outer_h)
  probe_pin [pec] = cylinder(axis=Z, base_centre=(0mm, y_kayma, yükseklik), radius=inner_radius, height=outer_h-yükseklik)
  port = circle(normal=Z, centre=(0mm, y_kayma, outer_h), radius=outer_rad)
  probe_pin_1 = probe_pin.copy()
  substrate.subtract(probe_pin_1)
  radiation [vacuum] = box(corner=(-100mm, -100mm, 20mm), size=(200mm, 200mm, -40mm))
  dielectric_1 = dielectric.copy()
  outer_conductor.subtract(dielectric_1)
  probe_pin_2 = probe_pin.copy()
  dielectric.subtract(probe_pin_2)
  probe_pin_3 = probe_pin.copy()
  substrate.subtract(probe_pin_3)
  pecCap1 [pec] = sweep_along_normal(port.face(at (0, 4.8, -15)), length=-0.21mm)
  Circle1 = circle(normal=Z, centre=(0mm, y_kayma, 0mm), radius=outer_rad)
  taban.subtract(Circle1)
  patch = circle(normal=Z, centre=(0mm, 0mm, yükseklik), radius=patch_rad)
boundaries and excitations:
  PerfE3: Perfect E Objects=taban
  Rad1: Radiation Objects=radiation
  PerfE4: Perfect E Objects=port
  PerfE5: Perfect E Objects=patch
  1: Wave Port Objects=port NumModes=1 Modes{Mode1{IntLine{(0, 4.8, -15) -> (0, 6.8, -15)} CharImp=Zpi}}
setups:
  Setup1: HfssDriven Frequency=3.6GHz MaxDeltaS=0.02 MaximumPasses=6 MinimumPasses=1 MinimumConvergedPasses=1 PercentRefinement=30 BasisOrder=1 PortAccuracy=2 DrivenSolverType="Direct Solver"
    sweep Sweep: 1.8GHz to 5.4GHz step 0.01GHz; Type=Interpolating InterpTolerance=0.5 InterpMaxSolns=250 InterpUsePortImped=false PassivityErrorTolerance=0.0001
    sweep Sweep1: point 3.1GHz; SaveSingleField Type=Discrete
    sweep Sweep2: point 5.18GHz; SaveSingleField Type=Discrete
source amplitudes:
  1:1: 1W 0deg
radiation setups:
  ff_2d: Infinite Sphere Theta=-180deg..180deg step 2deg Phi=0deg..90deg step 90deg
field plots:
  Vector_Jsurf1: Jsurf over patch.face on Setup1 : Sweep2 at Freq=5.18GHz Phase=0deg
  Vector_Jsurf2: Jsurf over patch.face probe_pin.face(all 3) on Setup1 : Sweep1 at Freq=3.1GHz Phase=0deg
reports:
  S Parameter Plot 1: dB(S(1,1)) vs Freq on Setup1 : Sweep; markers m1 at 3.1GHz, m2 at 5.18GHz
  Gain Plot 1: dB(GainTotal) vs Theta on Setup1 : Sweep1, ff_2d [Phi=all Freq=3.1GHz]
  Gain Plot 2: dB(GainTotal) vs Theta on Setup1 : Sweep2, ff_2d [Phi=all Freq=5.18GHz]
